* SPICE netlist generated by Yosys 0.9 (git sha1 1979e0b)

.SUBCKT _paramod_multi_and_SIZE_1 out e1
V0 out e1 DC 0
.ENDS _paramod_multi_and_SIZE_1

.SUBCKT _paramod_multi_and_SIZE_2 out e1.0 e1.1
X0 e1.1 e1.0 out __AND_
.ENDS _paramod_multi_and_SIZE_2

.SUBCKT _paramod_multi_and_SIZE_3 out e1.0 e1.1 e1.2
X0 W2 W1 out __AND_
X1 W1 e1.1 e1.2 _paramod_multi_and_SIZE_2
X2 W2 e1.0 _paramod_multi_and_SIZE_1
.ENDS _paramod_multi_and_SIZE_3

.SUBCKT multi_and out e1.0 e1.1 e1.2 e1.3 e1.4 e1.5
X0 W2 W1 out __AND_
X1 W1 e1.3 e1.4 e1.5 _paramod_multi_and_SIZE_3
X2 W2 e1.0 e1.1 e1.2 _paramod_multi_and_SIZE_3
.ENDS multi_and

************************
* end of SPICE netlist *
************************
