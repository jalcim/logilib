* SPICE netlist generated by Yosys 0.21+10 (git sha1 a21745052, gcc 13.1.6 -fPIC -Os)

.SUBCKT _paramod_multi_and_SIZE_s32'00000000000000000000000000000001 out e1
V0 e1 out DC 0
.ENDS _paramod_multi_and_SIZE_s32'00000000000000000000000000000001

.SUBCKT _paramod_multi_and_SIZE_s32'00000000000000000000000000000010 out e1.0 e1.1
X0 e1.1 e1.0 out __AND_
.ENDS _paramod_multi_and_SIZE_s32'00000000000000000000000000000010

.SUBCKT multi_and out e1.0 e1.1 e1.2
X0 W2 W1 out __AND_
X1 W1 e1.1 e1.2 _paramod_multi_and_SIZE_s32'00000000000000000000000000000010
X2 W2 e1.0 _paramod_multi_and_SIZE_s32'00000000000000000000000000000001
.ENDS multi_and

************************
* end of SPICE netlist *
************************
